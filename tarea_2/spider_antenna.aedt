# Ansys Electronics Desktop project, version 2018.1
materials:
  vacuum: permittivity=1
  copper: permeability=0.999991 conductivity=58000000

design HFSSDesign1 (HFSS, DrivenModal, model units mm)
variables:
  lambda = 275mm
  largo = lambda/4
  radio = largo/30
geometry:
  Cylinder1 [copper] = cylinder(axis=Z, base_centre=(0mm, 0mm, 0mm), radius=radio, height=largo)
